// Test topology - dc, ac, and tran with feedback
// Spectre

simulator lang=spectre

x1 (inp inn out vdd 0 bias 0 vdd) amp
vdd (vdd 0)        vsource dc=vdd
ibias (vdd bias)   isource dc=ibias
rfb (out1 inn)     resistor r=rfb
efb (out1 0 out 0) vcvs gain=1
rin (in inn)       resistor r=rin
vcom (inp 0)       vsource dc=vdd/2
vin (in1 inp)      vsource dc=0 mag=1
vinpulse (in in1)  vsource type=pulse val0=lev1 val1=lev2 delay=tstart rise=tr fall=tf width=pw
rload (out 0)      resistor r=rload
cload (out 0)      capacitor c=cload
